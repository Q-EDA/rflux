.title include-subckt-smoke
.include "include_stage_defs.inc"
V1 in 0 PULSE(0 1m 1p 0.2p 0.2p 2p 4p)
X1 in out stage params: rval=10 cval=1p
.tran 0.5p 10p
.end
