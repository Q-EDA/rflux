.title jj-second-harmonic-model-smoke
.model jjmod jj(icrit=0.5m rn=20 cj=0.5p icrit2=0.1m)
V1 in 0 PULSE(0,2m,0,1p,1p,2p,8p)
R1 in n1 10
J1 n1 0 model=jjmod icrit2=0.2m
.tran 0.25p 8p
.end
