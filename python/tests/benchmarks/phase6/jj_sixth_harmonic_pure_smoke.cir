.title jj-sixth-harmonic-pure-smoke
.model jjmod jj(rn=20 cj=0.5p icrit6=0.2m)
V1 in 0 PULSE(0,2m,0,1p,1p,2p,8p)
R1 in n1 10
J1 n1 0 model=jjmod icrit6=0.2m
.tran 0.25p 8p
.end
