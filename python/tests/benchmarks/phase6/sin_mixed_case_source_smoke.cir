.title sin mixed case source smoke
V1 in 0 sIn(0 1m 100g 0 90)
R1 in out 1
C1 out 0 1p
.tran 1p 5p
.end
