.title exp-rc-smoke
V1 in 0 EXP(0 1m 1p 0.5p 4p 0.5p)
R1 in out 10
C1 out 0 1p
.tran 0.5p 8p
.end
