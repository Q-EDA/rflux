.title include-chain-delay-source-pwl-jj-subckt-smoke
.include "include_chain_delay_source_pwl_jj_defs.inc"
X1 0 delay_source_jj_stage params: stage_z0=50 stage_td=3p stage_r=10
.tran 1p 8p
.end
