.title sin phase alias keyword mixed case comma source smoke
* Validates SIN source parsing with phase= alias, mixed-case keyword spelling, and comma-separated keyword arguments.
* Variant: mixed-case keyword form with comma separators and phase= alias instead of phi=.

V1 in 0 sIn(vo=0, va=1m, freq=100g, td=0, theta=300g, phase=90)
R1 in out 1k
C1 out 0 1p
.tran 1p 5p
.end
