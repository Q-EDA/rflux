.title sin alias source smoke
V1 in 0 SIN(offset=0 amplitude=1m f=100g td=0 damping=300g phi=90)
R1 in out 1
C1 out 0 1p
.tran 1p 5p
.end
