.title jj-native-cpr-model-smoke
.model jjmod jj(icrit=0.5m rn=20 cj=0.5p cpr={1,0.2,0.05})
V1 in 0 PULSE(0,2m,0,1p,1p,2p,8p)
R1 in n1 10
J1 n1 0 jjmod
.tran 0.25p 8p
.end
