.title include-chain-delay-subckt-smoke
.include "include_chain_delay_defs.inc"
V1 in 0 PULSE(0 1m 0 0.2p 0.2p 2p 6p)
X1 in out delay_stage params: stage_z0=50 stage_td=3p stage_r=50
.tran 0.5p 10p
.end
