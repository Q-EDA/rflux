.title lib sec keyword smoke
.lib "lib_sec_keyword_defs.inc" sec = TT
.tran 0.5p 20p
.end
