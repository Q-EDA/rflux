.title pulse mixed case source smoke
V1 in 0 pUlSe(0 1m 1p 0.2p 0.2p 2p 4p)
R1 in out 1
C1 out 0 1p
.tran 1p 10p
.end
