.title include-chain-source-pwl-k-jj-subckt-smoke
.include "include_chain_source_pwl_k_jj_defs.inc"
X1 0 tap source_pwl_coupled_jj_stage params: stage_k=0.9 stage_l=1p stage_r=10
.tran 1p 8p
.end
