.title include-source-pwl-k-jj-subckt-smoke
.include "include_source_pwl_k_jj_stage_defs.inc"
X1 tap source_pwl_coupled_jj_stage params: coupling=0.9 lval=1p rval=10
.tran 1p 8p
.end
