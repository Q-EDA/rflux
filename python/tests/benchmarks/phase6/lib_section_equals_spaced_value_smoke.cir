.title lib section equals spaced value smoke
.lib "lib_section_keyword_defs.inc" section= TT
.tran 0.5p 20p
.end
