.title include-chain-delay-source-pwl-subckt-smoke
.include "include_chain_delay_source_defs.inc"
X1 out delay_source_stage params: stage_z0=50 stage_td=3p stage_r=50
.tran 0.5p 10p
.end
