.title param rc smoke
.param vdd=1m tstep=0.5p tstop=10p
V1 in 0 PULSE(0 vdd 0 0.2p 0.2p 2p 4p)
R1 in out 10
C1 out 0 1p
.tran 0.5p 10p
.end
