.title include-chain-source-k-subckt-smoke
.include "include_chain_source_k_defs.inc"
X1 out tap source_coupled_stage params: stage_k=0.9 stage_l=1p stage_r=1
.tran 1p 8p
.end
