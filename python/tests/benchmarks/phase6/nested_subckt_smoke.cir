.title nested-subckt-smoke
.include "include_nested_stage_defs.inc"
V1 in 0 PULSE(0 1m 1p 0.2p 0.2p 2p 4p)
X1 in out stage params: stage_r=10 stage_c=1p
.tran 0.5p 10p
.end
